.SUBCKT LVS_CLEAN VDD FLOATPAD
.ENDS LVS_CLEAN
